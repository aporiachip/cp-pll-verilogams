`include "disciplines.vams"
`include "constants.vams"
module cp (up, dn, out);
  input up, dn; output out;
  electrical up, dn, out;
  parameter real icp=100u, vdd=1.8, vth=1.0, rout=100e6;
  real i_out;
  analog begin
    if(V(up)>vth&&V(dn)<vth) i_out=icp;
    else if(V(dn)>vth&&V(up)<vth) i_out=-icp;
    else if(V(up)>vth&&V(dn)>vth) i_out=0.0;
    else i_out=0.0;
    I(out) <+ transition(i_out,100p,20p,20p);
    I(out) <+ V(out)/rout;
    I(out) <+ white_noise(2e-22,"cp_th");
    I(out) <+ flicker_noise(2e-19,1.0,"cp_fl");  // was 5e-10
  end
endmodule
