// CP - Mixed: digital UP/DN inputs, analog current output
`include "disciplines.vams"
`include "constants.vams"

module cp(input up, input dn, output out);
  electrical out;

  parameter real icp  = 100u;
  parameter real vdd  = 1.8;
  parameter real vth  = 1.0;      // unused in digital, kept for compat
  parameter real rout = 100e6;

  real i_out;

  always @(*) begin
    if (up && !dn)          i_out =  icp;
    else if (dn && !up)     i_out = -icp;
    else                    i_out = 0.0;
  end

  analog begin
    I(out) <+ transition(i_out, 100p, 20p, 20p);
    I(out) <+ V(out) / rout;
    I(out) <+ white_noise(2e-22, "cp_th");
    I(out) <+ flicker_noise(2e-19, 1.0, "cp_fl");
  end
endmodule
