// Divider - Pure Verilog (VCO output is now digital reg)
`timescale 1ps/1ps

module divider(input clk_in, output reg clk_out);
  parameter integer N = 200;

  integer count;

  initial begin
    count = 0;
    clk_out = 0;
  end

  always @(posedge clk_in) begin
    count <= count + 1;
    if (count >= N/2 - 1) begin
      clk_out <= #50 ~clk_out;
      count   <= 0;
    end
  end
endmodule
