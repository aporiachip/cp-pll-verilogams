// Divider - Verilog-AMS: analog input (cross detection), digital output
`include "disciplines.vams"
`include "constants.vams"

module divider(clk_in, clk_out);
  input clk_in;                 // analog from VCO
  output reg clk_out;           // digital to PFD
  electrical clk_in;

  parameter integer N = 200;
  parameter real vdd = 1.8;
  parameter real vth = 0.9;
  parameter real trf = 30.0;

  integer count;

  initial begin
    count = 0;
    clk_out = 0;
  end

  // Cross detection: triggers on VCO rising edge
  always @(cross(V(clk_in) - vth, +1)) begin
    count = count + 1;
    if (count >= N/2) begin
      clk_out <= #50 ~clk_out;
      count = 0;
    end
  end
endmodule
