// PFD - Pure Verilog implementation
// Tri-state PFD with delayed reset, identical behavior to Verilog-A version
`timescale 1ps/1ps

module pfd(input ref, input fb, output reg up, output reg dn);
  parameter real vdd = 1.8;        // unused in digital (kept for compat)
  parameter real vth = 0.9;
  parameter real td_reset = 300.0; // reset delay in ps
  parameter real td_ff    = 80.0;  // FF propagation delay in ps
  parameter real trf      = 40.0;

  always @(posedge ref)  up <= #(td_ff) 1'b1;
  always @(posedge fb)   dn <= #(td_ff) 1'b1;

  always @(up or dn) begin
    if (up && dn) begin
      up <= #(td_reset) 1'b0;
      dn <= #(td_reset) 1'b0;
    end
  end
endmodule
