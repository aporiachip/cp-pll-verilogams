// VCO - Dual implementation
// `define USE_VERILOG → mixed: analog reads V(vin), digital self-oscillating
// undefined          → Verilog-A: idtmod phase accumulator
`include "disciplines.vams"
`include "constants.vams"

`ifdef USE_VERILOG

`timescale 1fs/1fs
module vco(vin, vout_p, vout_n);
  input vin; output reg vout_p; output vout_n;
  electrical vin;
  parameter real f0=10.0G, kvco=50.0M, vctrl0=0.9;
  parameter real vmin=0.0, vmax=1.8, vdd=1.8;
  real vin_a, vc, fv, hp_ps; integer hp_fs;
  analog begin vin_a = V(vin); end
  initial #1000 vout_p = 1'b1;
  always @(posedge vout_p) begin
    vc=vin_a; if(vc<vmin) vc=vmin; if(vc>vmax) vc=vmax;
    fv=f0+kvco*(vc-vctrl0); hp_ps=0.5e12/fv; hp_fs=hp_ps*1000.0;
    vout_p <= #(hp_fs) 1'b0;
  end
  always @(negedge vout_p) begin
    vc=vin_a; if(vc<vmin) vc=vmin; if(vc>vmax) vc=vmax;
    fv=f0+kvco*(vc-vctrl0); hp_ps=0.5e12/fv; hp_fs=hp_ps*1000.0;
    vout_p <= #(hp_fs) 1'b1;
  end
  assign vout_n = 1'b0;
endmodule

`else

module vco(vin, vout_p, vout_n);
  input vin; output vout_p, vout_n;
  electrical vin, vout_p, vout_n;
  parameter real f0=10.0G, kvco=50.0M, vctrl0=0.9;
  parameter real vmin=0.0, vmax=1.8, vdd=1.8;
  real freq, phase, clk_val, vctrl_clamped;
  analog begin
    vctrl_clamped = V(vin);
    if(vctrl_clamped<vmin) vctrl_clamped=vmin;
    if(vctrl_clamped>vmax) vctrl_clamped=vmax;
    freq = f0 + kvco*(vctrl_clamped-vctrl0);
    phase = idtmod(freq,0.0,1.0,-0.5);
    clk_val = (phase<0.0) ? vdd : 0.0;
    V(vout_p) <+ transition(clk_val,5p,5p,5p);
    V(vout_n) <+ 0.0;
  end
endmodule

`endif
