// VCO - Dual implementation
`include "disciplines.vams"
`include "constants.vams"

`ifdef USE_VERILOG

// Paper-based flicker PN (Hu, UCD 2019) — FIXED: separate randn for thermal/flicker
`timescale 1fs/1fs
module vco(vin, vout_p, vout_n);
  input vin; output reg vout_p; output vout_n;
  electrical vin;

  parameter real f0=10.0G, kvco=50.0M, vctrl0=0.9;
  parameter real vmin=0.0, vmax=1.8, vdd=1.8;
  parameter real L_1k=-60.0, L_10M=-120.0;

  real sigma_thermal, sigma_flicker;
  real a[0:4], A[0:4], y[0:4];
  real vin_a, vc, fv, hp_ps, half_period;
  integer hp_fs, seed_th, seed_fl, i;
  real rn_th, rn_fl, jitter_thermal, jitter_flicker, fl_in, fl_out;

  analog begin vin_a = V(vin); end

  initial begin
    sigma_thermal=(10.0e6/f0)*$sqrt(1.0/f0)*$sqrt(10.0**(L_10M/10.0));
    sigma_flicker=(1.0e3/f0) *$sqrt(1.0/f0)*$sqrt(10.0**(L_1k/10.0));
    a[0]=6.283e-7; A[0]=1.0;     a[1]=6.283e-6; A[1]=0.3162;
    a[2]=6.283e-5; A[2]=0.1;     a[3]=6.283e-4; A[3]=0.03162;
    a[4]=6.283e-3; A[4]=0.01;
    for(i=0;i<5;i=i+1) y[i]=0.0;
    seed_th=42; seed_fl=99; vout_p=0; #1000 vout_p=1;
  end

  always @(posedge vout_p) begin
    vc=vin_a; if(vc<vmin) vc=vmin; if(vc>vmax) vc=vmax;
    fv=f0+kvco*(vc-vctrl0); half_period=0.5e12/fv*1000.0;
    // Thermal: independent random number
    rn_th=$dist_normal(seed_th,0,1000)*1.0e-3;
    jitter_thermal=rn_th*sigma_thermal*1.0e15;
    // Flicker: independent random number, then through 5-IIR
    rn_fl=$dist_normal(seed_fl,0,1000)*1.0e-3;
    fl_in=rn_fl*sigma_flicker*1.0e15; fl_out=0.0;
    for(i=0;i<5;i=i+1) begin
      y[i]=(1.0-a[i])*y[i]+a[i]*A[i]*fl_in;
      fl_out=fl_out+y[i];
    end
    hp_fs=half_period+jitter_thermal+fl_out;
    if(hp_fs<10) hp_fs=10;
    vout_p <= #(hp_fs) 1'b0;
  end

  always @(negedge vout_p) begin
    vc=vin_a; if(vc<vmin) vc=vmin; if(vc>vmax) vc=vmax;
    fv=f0+kvco*(vc-vctrl0); half_period=0.5e12/fv*1000.0;
    rn_th=$dist_normal(seed_th,0,1000)*1.0e-3;
    jitter_thermal=rn_th*sigma_thermal*1.0e15;
    rn_fl=$dist_normal(seed_fl,0,1000)*1.0e-3;
    fl_in=rn_fl*sigma_flicker*1.0e15; fl_out=0.0;
    for(i=0;i<5;i=i+1) begin
      y[i]=(1.0-a[i])*y[i]+a[i]*A[i]*fl_in;
      fl_out=fl_out+y[i];
    end
    hp_fs=half_period+jitter_thermal+fl_out;
    if(hp_fs<10) hp_fs=10;
    vout_p <= #(hp_fs) 1'b1;
  end

  assign vout_n = 1'b0;
endmodule

`else

module vco(vin, vout_p, vout_n);
  input vin; output vout_p, vout_n;
  electrical vin, vout_p, vout_n, nz;
  parameter real f0=10.0G, kvco=50.0M, vctrl0=0.9;
  parameter real vmin=0.0, vmax=1.8, vdd=1.8;
  parameter real pn_1k=-60.0, pn_10k=-80.0, pn_1M=-120.0;
  real freq, phase, clk_val, vctrl_clamped;
  real L1k,L10k,L1M,Sf_w,Kf,Sv_w,Sv_fl;
  analog begin
    @(initial_step) begin
      L1k=pow(10.0,pn_1k/10.0); L10k=pow(10.0,pn_10k/10.0); L1M=pow(10.0,pn_1M/10.0);
      Sf_w=L1M*2.0*1.0e6*1.0e6; Kf=(L1k*2.0*1.0e3*1.0e3-Sf_w)*1.0e3;
      if(Kf<0.0) Kf=0.0; Sv_w=Sf_w; Sv_fl=Kf;
    end
    V(nz)<+white_noise(Sv_w,"fw"); if(Kf>0.0) V(nz)<+flicker_noise(Sv_fl,1.0,"ff");
    vctrl_clamped=V(vin);
    if(vctrl_clamped<vmin) vctrl_clamped=vmin;
    if(vctrl_clamped>vmax) vctrl_clamped=vmax;
    freq=f0+kvco*(vctrl_clamped-vctrl0)+V(nz);
    phase=idtmod(freq,0.0,1.0,-0.5);
    clk_val=(phase<0.0)?vdd:0.0;
    V(vout_p)<+transition(clk_val,5p,5p,5p);
    V(vout_n)<+0.0;
  end
endmodule

`endif
