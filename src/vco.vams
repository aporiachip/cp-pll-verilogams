// VCO - Mixed: analog reads voltage, computes period in fs for precision
`timescale 1fs/1fs
`include "disciplines.vams"
`include "constants.vams"

module vco(vin, vout_p, vout_n);
  input vin;
  output reg vout_p;
  output vout_n;
  electrical vin;

  parameter real f0     = 10.0G;
  parameter real kvco   = 50.0M;
  parameter real vctrl0 = 0.9;
  parameter real vmin   = 0.0;
  parameter real vmax   = 1.8;
  parameter real vdd    = 1.8;

  real vin_a, vc, fv, hp_ps;
  integer hp_fs;

  analog begin
    vin_a = V(vin);
  end

  initial #1000 vout_p = 1'b1;  // kick-start at 1ps

  always @(posedge vout_p) begin
    vc = vin_a;
    if (vc < vmin) vc = vmin;
    if (vc > vmax) vc = vmax;
    fv = f0 + kvco * (vc - vctrl0);
    hp_ps = 0.5e12 / fv;
    hp_fs = hp_ps * 1000.0;      // convert ps -> fs
    vout_p <= #(hp_fs) 1'b0;
  end

  always @(negedge vout_p) begin
    vc = vin_a;
    if (vc < vmin) vc = vmin;
    if (vc > vmax) vc = vmax;
    fv = f0 + kvco * (vc - vctrl0);
    hp_ps = 0.5e12 / fv;
    hp_fs = hp_ps * 1000.0;
    vout_p <= #(hp_fs) 1'b1;
  end

  assign vout_n = 1'b0;
endmodule
