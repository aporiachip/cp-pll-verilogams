// Testbench: Mixed Verilog/AMS
`include "disciplines.vams"
`include "constants.vams"

module tb_pll;
  reg ref;
  electrical vout_p, vout_n;     // analog from VCO
  electrical vtune, lock_det;    // analog from pll_top
  parameter real vdd = 1.8;

  // 50 MHz reference clock
  initial ref = 0;
  always #10000 ref = ~ref;

  // Monitor vctrl (analog block needed for V() access)
  analog begin
    $bound_step(50p);
    @(timer(0, 1u))
      $strobe("t=%0.1fus  vctrl=%.4f V", $abstime/1u, V(vtune));
  end

  pll_top #(.vdd(vdd)) i_pll (
    .ref(ref), .vout_p(vout_p), .vout_n(vout_n),
    .vtune(vtune), .lock_det(lock_det)
  );
endmodule
