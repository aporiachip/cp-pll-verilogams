// Testbench: Mixed Verilog/AMS
`include "disciplines.vams"
`include "constants.vams"

module tb_pll;
  reg ref;
  wire vout_p, vout_n;           // digital from VCO
  electrical vtune, lock_det;    // analog monitor
  parameter real vdd = 1.8;

  initial ref = 0;
  always #10000 ref = ~ref;

  analog begin
    $bound_step(50p);
    @(timer(0, 1u))
      $strobe("t=%0.1fus  vctrl=%.4f V", $abstime/1u, V(vtune));
  end

  pll_top #(.vdd(vdd)) i_pll (
    .ref(ref), .vout_p(vout_p), .vout_n(vout_n),
    .vtune(vtune), .lock_det(lock_det)
  );
endmodule
