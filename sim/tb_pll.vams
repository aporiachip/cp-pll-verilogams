// Testbench: Mixed Verilog/AMS
// ref generated by Verilog always block
// vctrl monitored by analog $strobe
`include "disciplines.vams"
`include "constants.vams"

module tb_pll;
  reg ref;
  wire vout_p, vout_n;
  wire vtune, lock_det;
  parameter real vdd = 1.8;

  // 50 MHz reference clock
  initial ref = 0;
  always #10000 ref = ~ref;   // 10ns = 10000ps half-period

  // Monitor vctrl every 1us (analog block needed to read electrical)
  analog begin
    $bound_step(50p);
    @(timer(0, 1u)) begin
      $strobe("t=%0.1fus  vctrl=%.4f V", $abstime/1u, V(vtune));
    end
  end

  pll_top #(.vdd(vdd)) i_pll (
    .ref(ref), .vout_p(vout_p), .vout_n(vout_n),
    .vtune(vtune), .lock_det(lock_det)
  );
endmodule
